* Universal Reticulum Hat: Power Path Automatic Switchover SPICE Simulation
* Target: ngspice
* Circuit: DMG2305UX P-MOSFET + BAT54C Schottky Diode Power Path with 500mA Load

.title Reticulum Hat Power Path Simulation

* --- Voltage Sources ---
* LiPo Battery: nominal 3.7V with 100mOhm internal resistance
Vbat_ideal n_bat_raw 0 DC 3.7V
Rbat_esr n_bat_raw n_bat 0.1

* USB 5V: Steps down from 5.0V to 0.0V at 10ms (simulating unplugging), steps back to 5.0V at 20ms
* PULSE(V1 V2 Tdelay Trise Tfall Ton Tperiod)
Vusb n_usb 0 PULSE(5.0 0.0 10m 10u 10u 10m 30m)

* --- Power Path Components ---
* D1 (BAT54C Diode 1): Conducts USB 5V to VSYS
D1 n_usb n_sys D_BAT54

* D2 (BAT54C Diode 2): Pulls up Gate of P-MOSFET to turn it OFF when USB is plugged in
D2 n_usb n_gate D_BAT54

* Gate pull-down resistor: 100k pulls Gate to GND when USB is unplugged
Rgate n_gate 0 100k

* P-Channel MOSFET (DMG2305UX: Drain=n_sys, Gate=n_gate, Source=n_bat)
M1 n_sys n_gate n_bat n_bat PMOS_DMG2305 W=10000u L=0.25u

* --- Output Filtering & Decoupling ---
* 20uF total capacitance (two 10uF 0805 MLCC in parallel) with 10mOhm ESR
R_esr n_sys n_cap 0.01
C_out n_cap 0 20uF

* --- System Load ---
* 500mA constant current sink (ESP32-C5 Wi-Fi 6 + LoRa TX + ST7789 LCD)
I_load n_sys 0 DC 0.5A

* --- Device Models ---
.model D_BAT54 D (IS=1e-8 RS=0.5 N=1.05 BV=30 IBV=10u CJO=10p VJ=0.6 M=0.33)
.model PMOS_DMG2305 PMOS (VTO=-0.8 KP=1.2 RS=0.02 RD=0.02 CGSO=1n CGDO=1n)

* --- Simulation Control ---
.tran 1u 30m 0 1u

.control
run
echo "=== Running Power Path Transient Simulation ==="
meas tran v_usb_high max v(n_usb) from=1m to=9m
meas tran v_sys_usb  avg v(n_sys) from=5m to=9m
meas tran v_sys_bat  avg v(n_sys) from=15m to=19m
meas tran v_sys_min  min v(n_sys) from=9.5m to=11m
let v_drop_sw = v_sys_bat - v_sys_min
echo "=== Power Path Measurement Results ==="
print v_usb_high v_sys_usb v_sys_bat v_sys_min v_drop_sw
quit
.endc

.end
